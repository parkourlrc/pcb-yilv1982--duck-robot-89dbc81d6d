AP64350 convergence test - source impedance + snubber variants
.include "C:/Users/yilv/AppData/Local/duck-robot-tools/models/diodes/AP64350/ap64350_patched.lib"
VSRC vsrc 0 DC 8.4
RIN  vsrc vin 50m
LIN  vin vin2 1u
CIN  vin2 0 20uCSNUB sw 0 1n
RSNUB sw 0 10
XU1  bst vin2 en rt fb comp 0 sw AP64350
L1   sw vout 5.5u
RESR vout cx 5m
COUT cx 0 44u
CBST sw bst 0.1u
RTOP vout fb 52.3k
RBOT fb 0 10k
RC   comp cc 14k
CC   cc 0 3.3n
REN1 vin2 en 100k
REN2 en 0 200k
RT   rt 0 0
ILOAD vout 0 PWL(0 0.5 1.4m 0.5 1.45m 3.5 2.4m 3.5)
.options rshunt=1e9
.tran 0.5u 2.5m
.meas tran vout_avg AVG V(vout) FROM=2.2m TO=2.4m
.meas tran vout_min MIN V(vout) FROM=2.2m TO=2.4m
.meas tran vout_max MAX V(vout) FROM=2.2m TO=2.4m
.end
