probe u() and E-source IF
V1 a 0 PWL(0 0 1u 1)
B2 b2 0 V = u(V(a) - 0.5)
B3 b3 0 V = min(max(V(a),0),0.8)
E4 b4 0 VALUE { IF(V(a) > 0.5, 1, 0) }
.tran 0.1u 1u
.print tran V(a) V(b2) V(b3) V(b4)
.end
