* Auto-generated testbench for decoupling analysis: VBATT_2S_IN rail
* 2 capacitor(s) in parallel, series R-L-C model
* Model: ESR/ESL from pdn_impedance (package-based)

R_esr_C303 rail n_esr_0 9.5m
L_par_C303 n_esr_0 n_lpar_0 1.1n
C303 n_lpar_0 0 10u
R_esr_C304 rail n_esr_1 9.5m
L_par_C304 n_esr_1 n_lpar_1 1.1n
C304 n_lpar_1 0 10u

* 1A AC current source into the rail node ¡ª V(rail) = Z(f)
IAC 0 rail DC 0 AC 1

.control
ac dec 200 100 100Meg
let z_mag = vm(rail)
meas ac z_min min z_mag
meas ac f_at_zmin when z_mag=z_min
meas ac z_at_1M find vm(rail) at=1Meg
meas ac z_at_100k find vm(rail) at=100k
echo "z_min=$&z_min f_at_zmin=$&f_at_zmin z_at_1M=$&z_at_1M z_at_100k=$&z_at_100k n_caps=2" > docs/references/hat-simulation-tools-20261029/metadata-repair-20261030/spice-work/decoupling_C303_C304.out
quit
.endc

.end
