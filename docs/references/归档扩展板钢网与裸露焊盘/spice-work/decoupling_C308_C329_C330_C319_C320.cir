* Auto-generated testbench for decoupling analysis: +3V3 rail
* 8 capacitor(s) in parallel, series R-L-C model
* Model: ESR/ESL from pdn_impedance (package-based)

R_esr_C308 rail n_esr_0 33.7m
L_par_C308 n_esr_0 n_lpar_0 900p
C308 n_lpar_0 0 2.2u
R_esr_C329 rail n_esr_1 948.7m
L_par_C329 n_esr_1 n_lpar_1 500p
C329 n_lpar_1 0 100n
R_esr_C330 rail n_esr_2 948.7m
L_par_C330 n_esr_2 n_lpar_2 500p
C330 n_lpar_2 0 100n
R_esr_C319 rail n_esr_3 948.7m
L_par_C319 n_esr_3 n_lpar_3 500p
C319 n_lpar_3 0 100n
R_esr_C320 rail n_esr_4 948.7m
L_par_C320 n_esr_4 n_lpar_4 500p
C320 n_lpar_4 0 100n
R_esr_C312 rail n_esr_5 948.7m
L_par_C312 n_esr_5 n_lpar_5 500p
C312 n_lpar_5 0 100n
R_esr_C313 rail n_esr_6 300m
L_par_C313 n_esr_6 n_lpar_6 500p
C313 n_lpar_6 0 1u
R_esr_C315 rail n_esr_7 300m
L_par_C315 n_esr_7 n_lpar_7 500p
C315 n_lpar_7 0 1u

* 1A AC current source into the rail node — V(rail) = Z(f)
IAC 0 rail DC 0 AC 1

.control
ac dec 200 100 100Meg
let z_mag = vm(rail)
meas ac z_min min z_mag
meas ac f_at_zmin when z_mag=z_min
meas ac z_at_1M find vm(rail) at=1Meg
meas ac z_at_100k find vm(rail) at=100k
echo "z_min=$&z_min f_at_zmin=$&f_at_zmin z_at_1M=$&z_at_1M z_at_100k=$&z_at_100k n_caps=8" > E:/Projects/duck-robot/docs/references/hat-stencil-20261102/spice-work/decoupling_C308_C329_C330_C319_C320.out
quit
.endc

.end
