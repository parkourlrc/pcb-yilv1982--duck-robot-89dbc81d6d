* Auto-generated testbench for decoupling analysis: +3V3 rail
* 13 capacitor(s) in parallel, series R-L-C model
* Model: ESR/ESL from pdn_impedance (package-based)

R_esr_C401 rail n_esr_0 316.2m
L_par_C401 n_esr_0 n_lpar_0 700p
C401 n_lpar_0 0 100n
R_esr_C402 rail n_esr_1 316.2m
L_par_C402 n_esr_1 n_lpar_1 700p
C402 n_lpar_1 0 100n
R_esr_C702 rail n_esr_2 100m
L_par_C702 n_esr_2 n_lpar_2 700p
C702 n_lpar_2 0 1u
R_esr_C705 rail n_esr_3 316.2m
L_par_C705 n_esr_3 n_lpar_3 700p
C705 n_lpar_3 0 100n
R_esr_C706 rail n_esr_4 100m
L_par_C706 n_esr_4 n_lpar_4 700p
C706 n_lpar_4 0 1u
R_esr_C707 rail n_esr_5 316.2m
L_par_C707 n_esr_5 n_lpar_5 700p
C707 n_lpar_5 0 100n
R_esr_C708 rail n_esr_6 100m
L_par_C708 n_esr_6 n_lpar_6 700p
C708 n_lpar_6 0 1u
R_esr_C709 rail n_esr_7 316.2m
L_par_C709 n_esr_7 n_lpar_7 700p
C709 n_lpar_7 0 100n
R_esr_C710 rail n_esr_8 100m
L_par_C710 n_esr_8 n_lpar_8 700p
C710 n_lpar_8 0 1u
R_esr_C711 rail n_esr_9 316.2m
L_par_C711 n_esr_9 n_lpar_9 700p
C711 n_lpar_9 0 100n
R_esr_C712 rail n_esr_10 100m
L_par_C712 n_esr_10 n_lpar_10 700p
C712 n_lpar_10 0 1u
R_esr_C713 rail n_esr_11 316.2m
L_par_C713 n_esr_11 n_lpar_11 700p
C713 n_lpar_11 0 100n
R_esr_C721 rail n_esr_12 316.2m
L_par_C721 n_esr_12 n_lpar_12 700p
C721 n_lpar_12 0 100n

* 1A AC current source into the rail node — V(rail) = Z(f)
IAC 0 rail DC 0 AC 1

.control
ac dec 200 100 100Meg
let z_mag = vm(rail)
meas ac z_min min z_mag
meas ac f_at_zmin when z_mag=z_min
meas ac z_at_1M find vm(rail) at=1Meg
meas ac z_at_100k find vm(rail) at=100k
echo "z_min=$&z_min f_at_zmin=$&f_at_zmin z_at_1M=$&z_at_1M z_at_100k=$&z_at_100k n_caps=13" > docs/references/hat-revb-cost-20261104/spice-work/decoupling_C401_C402_C702_C705_C706.out
quit
.endc

.end
