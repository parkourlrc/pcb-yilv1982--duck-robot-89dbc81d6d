* Auto-generated testbench for RC filter: R722/C724
* Type: RC-network, expected fc = 65.8 Hz
* Model: ideal passives (exact for RC)

R722 MIC_EXT_R MICBIAS 2.2k

C724 MICBIAS 0 1.1u

* AC stimulus
VAC MIC_EXT_R 0 DC 0 AC 1

.control
ac dec 100 657.7m 6.577k
meas ac fc_sim when vdb(MICBIAS)=-3
meas ac phase_fc find vp(MICBIAS) at=fc_sim
echo "fc_sim=$&fc_sim phase_fc=$&phase_fc has_parasitics=0" > docs/references/hat-revb-cost-20261104/spice-work/rc-filter_R722_C724.out
quit
.endc

.end
