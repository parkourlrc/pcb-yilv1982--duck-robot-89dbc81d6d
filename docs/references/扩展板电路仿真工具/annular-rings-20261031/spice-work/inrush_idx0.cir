* Auto-generated testbench for inrush analysis: U301 (switching)
* Output: 3.738V, 54.0µF total capacitance
* Soft-start: 1.0ms ramp

* Voltage source with linear ramp (soft-start) — 10us delay before ramp
Vreg ramp 0 PWL(0 0 10u 0 1.01m 3.738)
* Regulator output impedance
Rout ramp out 10m

* Output capacitors
C305 out 0 22u
C306 out 0 22u
C323 out 0 10u

.control
tran 2u 3m
let i_out = abs(i(Rout))
let i_peak = vecmax(i_out)
let t_peak = i_out[vecmin(abs(i_out - i_peak))]
meas tran v_settled find v(out) at=2.7m
echo "i_peak=$&i_peak t_peak=$&t_peak v_settled=$&v_settled v_target=3.738 r_out=0.01" > E:/Projects/duck-robot/docs/references/hat-simulation-tools-20261029/annular-rings-20261031/spice-work/inrush_idx0.out
quit
.endc

.end
