* Auto-generated testbench for RC filter: R308/C310
* Type: low-pass, expected fc = 159.2 Hz
* Model: ideal passives (exact for RC)

R308 _3V3 CODEC_RST 10k

C310 CODEC_RST 0 100n

* AC stimulus
VAC _3V3 0 DC 0 AC 1

.control
ac dec 100 1.592 15.91k
meas ac fc_sim when vdb(CODEC_RST)=-3
meas ac phase_fc find vp(CODEC_RST) at=fc_sim
echo "fc_sim=$&fc_sim phase_fc=$&phase_fc has_parasitics=0" > E:/Projects/duck-robot/docs/references/hat-simulation-tools-20261029/board-marking-20261031/spice-work/rc-filter_R308_C310.out
quit
.endc

.end
